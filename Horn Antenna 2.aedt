# Ansys Electronics Desktop project, version 2025.2
materials:
  vacuum: permittivity=1
  pec: conductivity=1e+30
  Material1: permittivity=2 dielectric_loss_tangent=0.01
  copper: permeability=0.999991 conductivity=58000000
  polyethylene: permittivity=2.25 dielectric_loss_tangent=0.001

design PEC_Inside (HFSS, HFSS Modal Network, model units mm)
variables:
  a = 20mm
  b = 10mm
  c = 50mm
  aa = 100mm
  bb = 50mm
  L = 100mm
  lambda = 30mm
geometry:
  Box1 = box(corner=(-a/2, -b/2, 0mm), size=(a, b, c))
  Rectangle1 = rectangle(corner=(-aa/2, -bb/2, c+L), x_size=aa, y_size=bb)
  Box1_ObjectFromFace1 = object_from(Box1.face(+z))
  Rectangle1_ObjectFromFace1 = object_from(Rectangle1.face(at (0, 0, 150)))
  Rectangle1.delete()
  Box1_ObjectFromFace1_ObjectFromFace1 = object_from(Box1_ObjectFromFace1.face)
  Box1_ObjectFromFace1.delete()
  Rectangle1_ObjectFromFace1.connect(Box1_ObjectFromFace1_ObjectFromFace1)
  Rectangle1_ObjectFromFace1_Detach1..Rectangle1_ObjectFromFace1_Detach4 = Rectangle1_ObjectFromFace1.detach(Rectangle1_ObjectFromFace1.face(at (0, 15, 100), at (30, 0, 100), at (-30, 0, 100), at (0, -15, 100)))
  Rectangle1_ObjectFromFace1.delete()
  Horn, Box1_Detach2, Box1_Detach3, Box1_Detach4 = Box1.detach(Box1.face(+y, +x, -y, -x))
  Box1.delete()
  Horn.unite(Box1_Detach2, Box1_Detach3, Box1_Detach4, Rectangle1_ObjectFromFace1_Detach1..Rectangle1_ObjectFromFace1_Detach4)
  Port = rectangle(corner=(-a/2, -b/2, 0mm), x_size=a, y_size=b)
  AirBox [vacuum] = box(corner=(-aa/2 - lambda/4, -bb/2 - lambda/4, -lambda/4), size=(aa + lambda/2, bb + lambda/2, c + L + lambda/2))
  PEC [pec] = box(corner=(-a/2, -b/2, 0mm), size=(a, b, 2.23mm))
boundaries and excitations:
  PerfE1: Perfect E Objects=Horn
  Rad1: Radiation Objects=AirBox
  1: Wave Port Faces=Port.face WavePortType=Modal NumModes=1 Modes{Mode1{IntLine{(0, -5, 0) -> (0, 5, 0)} CharImp=Zpi}}
setups:
  Setup1: HfssDriven Frequency=10GHz MaxDeltaS=0.02 MaximumPasses=20 MinimumPasses=1 MinimumConvergedPasses=1 PercentRefinement=30 BasisOrder=1 PortAccuracy=2 DrivenSolverType="Direct Solver"
    sweep Sweep: point 10GHz; Type=Discrete
source amplitudes:
  1:1: 1W 0deg
radiation setups:
  Infinite Sphere1: Infinite Sphere Theta=-180deg..180deg step 2deg Phi=-180deg..180deg step 2deg
field plots:
  Mag_E1: E Field over a plane on Setup1 : LastAdaptive at Freq=10GHz Phase=0deg
reports:
  Gain Plot1: dB(GainTotal) vs Phi, Theta on Setup1 : LastAdaptive, Infinite Sphere1 [Freq=10GHz]

design PEC_Outside (HFSS, HFSS Modal Network, model units mm)
variables:
  a = 20mm
  b = 10mm
  c = 50mm
  aa = 140mm
  bb = 70mm
  L = 150mm
  lambda = 25mm
geometry:
  Box1 = box(corner=(-a/2, -b/2, 0mm), size=(a, b, c))
  Rectangle1 = rectangle(corner=(-aa/2, -bb/2, c+L), x_size=aa, y_size=bb)
  Box1_ObjectFromFace1 = object_from(Box1.face(+z))
  Rectangle1_ObjectFromFace1 = object_from(Rectangle1.face(at (0, 0, 200)))
  Rectangle1.delete()
  Box1_ObjectFromFace1_ObjectFromFace1 = object_from(Box1_ObjectFromFace1.face)
  Box1_ObjectFromFace1.delete()
  Rectangle1_ObjectFromFace1.connect(Box1_ObjectFromFace1_ObjectFromFace1)
  Rectangle1_ObjectFromFace1_Detach1..Rectangle1_ObjectFromFace1_Detach4 = Rectangle1_ObjectFromFace1.detach(Rectangle1_ObjectFromFace1.face(at (0, 20, 125), at (40, 0, 125), at (-40, 0, 125), at (0, -20, 125)))
  Rectangle1_ObjectFromFace1.delete()
  Horn, Box1_Detach2, Box1_Detach3, Box1_Detach4 = Box1.detach(Box1.face(+y, +x, -y, -x))
  Box1.delete()
  Horn.unite(Box1_Detach2, Box1_Detach3, Box1_Detach4, Rectangle1_ObjectFromFace1_Detach1..Rectangle1_ObjectFromFace1_Detach4)
  Port = rectangle(corner=(-a/2, -b/2, 0mm), x_size=a, y_size=b)
  AirBox [vacuum] = box(corner=(-aa/2 - lambda/4, -bb/2 - lambda/4, -lambda/4), size=(aa + lambda/2, bb + lambda/2, c + L + lambda/2))
  PEC [pec] = box(corner=(-a/2, -b/2, 0mm), size=(a, b, -2.23mm))
  Box2 = box(corner=(-a/2, -b/2, 0mm), size=(a, b, c))
  Rectangle2 = rectangle(corner=(-aa/2, -bb/2, c+L), x_size=aa, y_size=bb)
  Box2_ObjectFromFace1 [Material1] = object_from(Box2_ObjectFromFace1.face(at (0, 0, 50)))
  Rectangle2_ObjectFromFace1 = object_from(Rectangle2.face(at (0, 0, 200)))
  Rectangle2.delete()
  Box2_ObjectFromFace1.connect(Rectangle2_ObjectFromFace1)
  Box2_ObjectFromFace1.unite(Box2)
boundaries and excitations:
  PerfE1: Perfect E Objects=Horn
  Rad1: Radiation Objects=AirBox
  1: Wave Port Faces=Port.face WavePortType=Modal NumModes=1 Modes{Mode1{IntLine{(0, -5, 0) -> (0, 5, 0)} CharImp=Zpi}}
setups:
  Setup1: HfssDriven Frequency=12GHz MaxDeltaS=0.02 MaximumPasses=20 MinimumPasses=1 MinimumConvergedPasses=1 PercentRefinement=30 BasisOrder=1 PortAccuracy=2 DrivenSolverType="Direct Solver"
    sweep Sweep: point 12GHz; Type=Discrete
source amplitudes:
  1:1: 1W 0deg
radiation setups:
  Infinite Sphere1: Infinite Sphere Theta=-180deg..180deg step 2deg Phi=-180deg..180deg step 2deg
field plots:
  Mag_E1, Mag_E2: E Field over a plane on Setup1 : LastAdaptive at Freq=12GHz Phase=0deg
reports:
  Gain Plot1: dB(GainTotal) vs Phi, Theta on Setup1 : LastAdaptive, Infinite Sphere1 [Freq=12GHz]
  Gain Plot2: dB(GainTotal) vs Theta on Setup1 : LastAdaptive, Infinite Sphere1 [Phi=90deg Freq=12GHz]

design AUEG_RT (HFSS, HFSS Modal Network, model units mm)
options: Allow_Material_Override
variables:
  a = 146mm
  b = 117mm
  c = 230mm
  aa = 750mm
  bb = 600mm
  L = 700mm
  lambda = 211mm
  L_ant = 52.5mm
  d = 76.4mm
  r1 = 9.5mm
  r2 = 1mm
geometry:
  Box1 = box(corner=(-a/2, -b/2, 0mm), size=(a, b, c))
  Rectangle1 = rectangle(corner=(-aa/2, -bb/2, c+L), x_size=aa, y_size=bb)
  Box1_ObjectFromFace1 = object_from(Box1.face(+z))
  Rectangle1_ObjectFromFace1 = object_from(Rectangle1.face(at (0, 0, 930)))
  Rectangle1.delete()
  Box1_ObjectFromFace1_ObjectFromFace1 = object_from(Box1_ObjectFromFace1.face)
  Box1_ObjectFromFace1.delete()
  Rectangle1_ObjectFromFace1.connect(Box1_ObjectFromFace1_ObjectFromFace1)
  Rectangle1_ObjectFromFace1_Detach1..Rectangle1_ObjectFromFace1_Detach4 = Rectangle1_ObjectFromFace1.detach(Rectangle1_ObjectFromFace1.face(at (0, 179.25, 580), at (224, 0, 580), at (-224, 0, 580), at (0, -179.25, 580)))
  Rectangle1_ObjectFromFace1.delete()
  Horn, Box1_Detach2, Box1_Detach3, Box1_Detach4 = Box1.detach(Box1.face(+y, +x, -y, -x))
  Box1.delete()
  Horn.unite(Box1_Detach2, Box1_Detach3, Box1_Detach4, Rectangle1_ObjectFromFace1_Detach1..Rectangle1_ObjectFromFace1_Detach4)
  Port = rectangle(corner=(-a/2, -b/2, 0mm), x_size=a, y_size=b)
  AirBox [vacuum] = box(corner=(-aa/2 - lambda/4, -bb/2 - lambda/4, -lambda/4), size=(aa + lambda/2, bb + lambda/2, c + L + lambda/2))
  PEC [pec] = box(corner=(-a/2, -b/2, 0mm), size=(a, b, -2.23mm))
  Box2 = box(corner=(-a/2, -b/2, 0mm), size=(a, b, c))
  Rectangle2 = rectangle(corner=(-aa/2, -bb/2, c+L), x_size=aa, y_size=bb)
  Box2_ObjectFromFace1 [Material1] = object_from(Box2_ObjectFromFace1.face(at (0, 0, 230)))
  Rectangle2_ObjectFromFace1 = object_from(Rectangle2.face(at (0, 0, 930)))
  Rectangle2.delete()
  Box2_ObjectFromFace1.connect(Rectangle2_ObjectFromFace1)
  Box2_ObjectFromFace1.unite(Box2)
  plane Plane1 = base (0mm, 0mm, 60mm) normal (0mm, 0mm, -60mm)
  Dielectric_1 [polyethylene] = cylinder(axis=Y, base_centre=(0mm, b/2, d), radius=9.5mm, height=lambda/2)
  Cylinder2 [copper] = cylinder(axis=Y, base_centre=(0mm, b/2-L_ant, d), radius=1mm, height=L_ant)
boundaries and excitations:
  PerfE1: Perfect E Objects=Horn
  Rad1: Radiation Objects=AirBox
  PerfE3: Perfect E Objects=Port
  1: Wave Port Faces=Port.face WavePortType=Modal NumModes=1 Modes{Mode1{IntLine{(0, -58.5, 0) -> (0, 58.5, 0)} CharImp=Zpi}}
  2: Lumped Port Faces=Cylinder2.face(+y end) LumpedPortType=Modal Modes{Mode1{IntLine{(0, 58.5, 75.4) -> (0, 58.5, 77.4)} CharImp=Zpi}} Impedance=50ohm
setups:
  Setup1: HfssDriven Frequency=1.42GHz MaxDeltaS=0.01 MaximumPasses=20 MinimumPasses=1 MinimumConvergedPasses=1 PercentRefinement=30 BasisOrder=1 PortAccuracy=2 DrivenSolverType="Direct Solver"
    sweep Sweep: 1GHz to 5GHz step 0.25GHz; Type=Interpolating InterpTolerance=0.5 InterpMaxSolns=250 InterpUsePortImped=false PassivityErrorTolerance=0.0001
source amplitudes:
  1:1: 1W 0deg
  2:1: 0W 0deg
radiation setups:
  Infinite Sphere1: Infinite Sphere Theta=-180deg..180deg step 2deg Phi=-180deg..180deg step 2deg
field plots:
  Mag_E1, Mag_E2: E Field over a plane on Setup1 : LastAdaptive at Freq=1.42GHz Phase=0deg
reports:
  Gain Plot1: dB(GainTotal) vs Phi, Theta on Setup1 : LastAdaptive, Infinite Sphere1 [Freq=1.42GHz]
  Gain Plot3: dB(GainTotal) vs Theta on Setup1 : LastAdaptive, Infinite Sphere1 [Phi=0deg,90deg Freq=1.42GHz aa=750mm L=700mm]
  VSWR Plot1: dB(VSWR(1)) vs Freq on Setup1 : Sweep; markers MX1 at x=1.42e+09
  Gain Plot4: abs(GainTotal) vs Theta on Setup1 : LastAdaptive, Infinite Sphere1 [Phi=0deg,90deg Freq=1.42GHz]
  S Parameter Plot1: dB(S(1,1)) vs Freq on Setup1 : Sweep
